another line addition
// Ideal Opamp
//
// Version 1a, 1 June 04
//
// Ken Kundert
//
// Downloaded from The Designer's Guide Community (www.designers-guide.org).
// Post any questions on www.designers-guide.org/Forum.
// Taken from "The Designer's Guide to Verilog-AMS" by Kundert & Zinke.
// Chapter 5, Listing 1.

`include "disciplines.vams"

module ideal_opamp (pout, nout, pin, nin);
    output pout, nout;
    input pin, nin;
    electrical pin, nin, pout, nout;
    branch (pout,nout) out;
    branch (pin,nin) in;

    analog begin
	V(out): V(in) == 0;
    end
endmodule
